* Inhibit contact DC model; pulldown range is a sensitivity scenario, not measured module values.
Vsup vcc 0 5.25
Rnc vcc en 1000000000000.0
Rpd1 en 0 100000
Rpd2 en 0 100000
Ileak vcc en 2u
.control
op
wrdata 5.25V_100kOhm_contact-open.txt v(en)
quit
.endc
.end
