* Inhibit contact DC model; pulldown range is a sensitivity scenario, not measured module values.
Vsup vcc 0 5
Rnc vcc en 0.1
Rpd1 en 0 100000
Rpd2 en 0 100000
Ileak vcc en 2u
.control
op
wrdata v5_100000_1.txt v(en)
quit
.endc
.end
