* Inhibit contact DC model; pulldown range is a sensitivity scenario, not measured module values.
Vsup vcc 0 4.75
Rnc vcc en 1000000000000.0
Rpd1 en 0 1000
Rpd2 en 0 1000
Ileak vcc en 2u
.control
op
wrdata v4.75_1000_0.txt v(en)
quit
.endc
.end
